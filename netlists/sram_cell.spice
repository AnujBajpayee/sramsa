* ==========================================
* SRAM Subcircuits using PTM 130nm (BSIM4)
* ==========================================

* --- 6T SRAM Bitcell Subcircuit ---
.subckt sram_6t Q QB BL BLB WL VDD VSS
M_PD1 Q QB VSS VSS nmos w=1.0u l=0.15u
M_PU1 Q QB VDD VDD pmos w=1.5u l=0.15u
M_PD2 QB Q VSS VSS nmos w=1.0u l=0.15u
M_PU2 QB Q VDD VDD pmos w=1.5u l=0.15u
M_AX1 Q WL BL VSS nmos w=1.2u l=0.15u
M_AX2 QB WL BLB VSS nmos w=1.2u l=0.15u
.ends sram_6t

* --- Bitline Pre-charge & Equalization Circuit ---
.subckt sram_precharge bl blb vdd pre_b
MP1 bl  pre_b vdd vdd pmos w=2.0u l=0.15u
MP2 blb pre_b vdd vdd pmos w=2.0u l=0.15u
MPEQ bl blb vdd vdd pmos w=1.0u l=0.15u
.ends sram_precharge

* --- Voltage-Latched Sense Amplifier Subcircuit ---
.subckt voltage_sense_amp bl blb vdd gnd saen iso out_p out_n
M_iso1 bl  iso out_p gnd nmos w=1.0u l=0.15u
M_iso2 blb iso out_n gnd nmos w=1.0u l=0.15u
MP1 out_p out_n vdd vdd pmos w=1.5u l=0.15u
MP2 out_n out_p vdd vdd pmos w=1.5u l=0.15u
MN1 out_p out_n net_tail gnd nmos w=2.0u l=0.15u
MN2 out_n out_p net_tail gnd nmos w=2.0u l=0.15u
M_tail net_tail saen gnd gnd nmos w=3.0u l=0.15u
.ends voltage_sense_amp
