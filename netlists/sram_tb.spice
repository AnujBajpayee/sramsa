* ==========================================
* Top-Level SRAM Read Path Testbench (PTM)
* ==========================================

* Include PTM Physics-Based Model File
.include "C:/sramsa/models/ptm/ptm130.pm"

* Include Subcircuit Netlist Definitions
.include "sram_cell.spice"

* Global Power Supplies
V_DD vdd 0 1.8
V_SS vss 0 0

* Module Instantiations
Xcell  q_node qb_node bl blb wl vdd vss sram_6t
Xpre   bl blb vdd pre_b sram_precharge
Xsense bl blb vdd vss saen iso out_p out_n voltage_sense_amp

* Testbench Control Clocks & Stimulus Pulses
V_PRE  pre_b 0 pulse(1.8 0 0 0.1ns 0.1ns 4.9ns 20ns)
V_WL   wl    0 pulse(0 1.8 6ns 0.1ns 0.1ns 4ns 20ns)
V_ISO  iso   0 pulse(0 1.8 5.8ns 0.1ns 0.1ns 5ns 20ns)
V_SAEN saen  0 pulse(0 1.8 7.5ns 0.1ns 0.1ns 3ns 20ns)

* Simulation Control & Raw File Export
.control
op
tran 0.01ns 20ns
write C:/sramsa/results/sram_tran.raw v(bl) v(blb) v(out_p) v(out_n) v(wl) v(saen)
.endc

.end
